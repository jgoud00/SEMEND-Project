Ideal-buffer Sallen-Key candidate; no device model or notch
.temp 25.0
Vin input 0 DC 0 AC 1 PULSE(0 0.001 0.01 1u 1u 0.05 0.1)
Eina stage0 0 input 0 9.998178506375227
C01 stage0 n0a 1e-07
C02 n0a n0b 1e-07
R01 n0a stage1 56269.7697598191
R02 n0b 0 112539.539519638
Ebuffer0 stage1 0 n0b 0 1
R11 stage1 n1a 32675.554315689
R12 n1a n1b 32675.554315689
C11 n1a stage2 1.17157287525381e-08
C12 n1b 0 1e-08
Ebuffer1 stage2 0 n1b 0 1
R21 stage2 n2a 13534.6577556171
R22 n2a n2b 13534.6577556171
C21 n2a stage3 6.82842712474619e-08
C22 n2b 0 1e-08
Ebuffer2 stage3 0 n2b 0 1
Epost out 0 stage3 0 50.0
.control
set noaskquit
set wr_singlescale
set wr_vecnames
ac dec 100 1 10000
wrdata ideal-ac.txt v(out)
tran 0.00005 0.15
wrdata ideal-transient.txt v(input) v(out)
noise v(out) Vin lin 1001 20 450 1
setplot noise1
wrdata ideal-noise.txt onoise_spectrum
quit
.endc
.end
